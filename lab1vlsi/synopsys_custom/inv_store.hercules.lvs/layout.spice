* SPICE INPUT		Sat May 23 21:14:30 2026	inv_store
* EV_NETLIST Version AMD.64 Release B-2008.09.SP5.26005 2012/07/14
*
*The following line needed for Star-CR:
*CRU_OPT (KEEP_ELEMENTS "^[CR]D")
*
*The following line needed for CDL:
*.BIPOLAR

* Top of hierarchy  cell=inv_store
.subckt inv_store gnd! out vdd! in
M_MM0 gnd! in out ln_N_9 N  l=0.100u w=0.120u
M_MM1 vdd! in out ln_N_12 P  l=0.100u w=0.300u
.ends inv_store
