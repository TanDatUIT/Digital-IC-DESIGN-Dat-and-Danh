* SPICE INPUT		Wed May 20 01:48:07 2026	Final
* EV_NETLIST Version AMD.64 Release B-2008.09.SP5.26005 2012/07/14
*
*The following line needed for Star-CR:
*CRU_OPT (KEEP_ELEMENTS "^[CR]D")
*
*The following line needed for CDL:
*.BIPOLAR

* Top of hierarchy  cell=Final
.subckt Final gnd! vdd! Cout S B A
M_XI11/MM3 gnd! net8 XI11/net19 ln_N_200 N  l=0.100u w=0.240u
M_XI11/MM2 XI11/net19 net7 net5 ln_N_200 N  l=0.100u w=0.240u
M_XI10/MM3 gnd! B XI10/net19 ln_N_200 N  l=0.100u w=0.240u
M_XI10/MM2 XI10/net19 A net2 ln_N_200 N  l=0.100u w=0.240u
M_XI12/MM3 gnd! B XI12/net19 ln_N_200 N  l=0.100u w=0.240u
M_XI12/MM2 XI12/net19 net2 net8 ln_N_200 N  l=0.100u w=0.240u
M_XI9/MM3 gnd! net2 XI9/net19 ln_N_200 N  l=0.100u w=0.240u
M_XI9/MM2 XI9/net19 A net7 ln_N_200 N  l=0.100u w=0.240u
M_XI13/MM3 gnd! net1 XI13/net19 ln_N_200 N  l=0.100u w=0.240u
M_XI13/MM2 XI13/net19 net5 net3 ln_N_200 N  l=0.100u w=0.240u
M_XI17/MM2 XI17/net19 net1 Cout ln_N_200 N  l=0.100u w=0.240u
M_XI17/MM3 gnd! net2 XI17/net19 ln_N_200 N  l=0.100u w=0.240u
M_XI16/MM3 gnd! net4 XI16/net19 ln_N_200 N  l=0.100u w=0.240u
M_XI16/MM2 XI16/net19 net3 S ln_N_200 N  l=0.100u w=0.240u
M_XI14/MM2 XI14/net19 net5 net1 ln_N_200 N  l=0.100u w=0.240u
M_XI14/MM3 gnd! ln_N_188 XI14/net19 ln_N_200 N  l=0.100u w=0.240u
M_XI15/MM2 XI15/net19 net1 net4 ln_N_200 N  l=0.100u w=0.240u
M_XI15/MM3 gnd! ln_N_188 XI15/net19 ln_N_200 N  l=0.100u w=0.240u
M_XI11/MM0 vdd! net8 net5 ln_N_233 P  l=0.100u w=0.300u
M_XI11/MM1 net5 net7 vdd! ln_N_233 P  l=0.100u w=0.300u
M_XI15/MM1 net4 net1 vdd! ln_N_233 P  l=0.100u w=0.300u
M_XI15/MM0 vdd! ln_N_188 net4 ln_N_233 P  l=0.100u w=0.300u
M_XI13/MM0 vdd! net1 net3 ln_N_233 P  l=0.100u w=0.300u
M_XI13/MM1 net3 net5 vdd! ln_N_233 P  l=0.100u w=0.300u
M_XI17/MM1 Cout net1 vdd! ln_N_233 P  l=0.100u w=0.300u
M_XI17/MM0 vdd! net2 Cout ln_N_233 P  l=0.100u w=0.300u
M_XI14/MM1 net1 net5 vdd! ln_N_233 P  l=0.100u w=0.300u
M_XI14/MM0 vdd! ln_N_188 net1 ln_N_233 P  l=0.100u w=0.300u
M_XI12/MM0 vdd! B net8 ln_N_233 P  l=0.100u w=0.300u
M_XI10/MM0 vdd! B net2 ln_N_233 P  l=0.100u w=0.300u
M_XI12/MM1 net8 net2 vdd! ln_N_233 P  l=0.100u w=0.300u
M_XI9/MM0 vdd! net2 net7 ln_N_233 P  l=0.100u w=0.300u
M_XI9/MM1 net7 A vdd! ln_N_233 P  l=0.100u w=0.300u
M_XI10/MM1 net2 A vdd! ln_N_233 P  l=0.100u w=0.300u
M_XI16/MM0 vdd! net4 S ln_N_233 P  l=0.100u w=0.300u
M_XI16/MM1 S net3 vdd! ln_N_233 P  l=0.100u w=0.300u
.ends Final
