*Custom Compiler Version N-2017.12-SP1-2
*Tue Apr 14 15:21:09 2026

*.SCALE METER
*.LDD

********************************************************************************
* Library          : BaiTap2
* Cell             : NMOS
* View             : schematic
* View Search List : auCdl schematic symbol
* View Stop List   : auCdl
********************************************************************************
.subckt NMOS D G S
*.PININFO D:O G:I S:O
MM0 D G S S N w=0.2u l=0.1u nf=1 m=1
.ends NMOS
