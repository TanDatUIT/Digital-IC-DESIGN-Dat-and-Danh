* SPICE INPUT		Tue Apr 14 15:21:11 2026	NMOS
* EV_NETLIST Version AMD.64 Release B-2008.09.SP5.26005 2012/07/14
*
*The following line needed for Star-CR:
*CRU_OPT (KEEP_ELEMENTS "^[CR]D")
*
*The following line needed for CDL:
*.BIPOLAR

* Top of hierarchy  cell=NMOS
.subckt NMOS ln_S ln_D ln_G
M_MM0 S G D ln_N_5 N  l=0.100u w=0.200u
.ends NMOS
